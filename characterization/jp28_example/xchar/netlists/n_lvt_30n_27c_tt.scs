// Design: dev28_adair/tb_char_min_l
simulator lang=spectre
global 0
parameters i_swp=100p
parameters temperature=27
include "/research/ece/lcas/pdk/tsmc/t28muse_hpcplus_rf_1p10m_5x2y2r_1v8/models/spectre/toplevel.scs" section=top_tt
// dev28_adair/tb_char_min_l/schematic_lvt_min_l
MNU (net2 net2 0 0) nch_lvt_mac l=100n w=100n multi=1 nf=1
MN0 (net1 net1 0 0) nch_lvt_mac l=30n w=100n multi=1 nf=1
I4 (0 net2) isource dc=i_swp type=dc
I1 (0 net1) isource dc=i_swp type=dc

simulatorOptions options temp=temperature
dcOp dc
