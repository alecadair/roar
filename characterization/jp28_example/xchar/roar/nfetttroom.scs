// Design cell name: tb_characterization_nfet
// Design view name: schematic
simulator lang=spectre
global 0
include "/research/ece/lcas/pdk/tsmc/t28muse_hpcplus_rf_1p10m_5x2y2r_1v8/tsmcN28/../models/spectre/toplevel.scs" section=top_tt
parameters vdg=100m i_swp=200p wireopt=120
include "n_netlist"
simulatorOptions options psfversion="1.4.0" reltol=1e-3 vabstol=1e-6 \
    iabstol=1e-12 temp=27 tnom=27 scalem=1.0 scale=1.0 gmin=1e-12 \
    rforce=1 vthmod=vthcc ivthn=300e-9 ivthp=70e-9 ivthw=0 ivthl=0 \
    maxnotes=5 maxwarns=5 digits=5 cols=80 pivrel=1e-3 \
    sensfile="../psf/sens.output" checklimitdest=psf vdsatmod=gds
dcOp dc write="spectre.dc" maxiters=150 maxsteps=10000 annotate=status
dcOpInfo info what=oppoint where=rawfile
dc dc param=i_swp start=100p stop=1m dec=20 oppoint=rawfile maxiters=150 \
    maxsteps=10000 annotate=status
modelParameter info what=models where=rawfile
element info what=inst where=rawfile
outputParameter info what=output where=rawfile
designParamVals info what=parameters where=rawfile
primitives info what=primitives where=rawfile
subckts info what=subckts where=rawfile
saveOptions options save=allpub
